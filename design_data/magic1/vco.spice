* NGSPICE file created from vco.ext - technology: sky130A

.subckt sky130_fd_pr__nfet_01v8_QMGPN5 B D0 G S1 D2 S3 D4 S4
X0 S1 G D0 B sky130_fd_pr__nfet_01v8 ad=0.29 pd=2.29 as=0.58 ps=4.58 w=2 l=1
X1 D2 G S1 B sky130_fd_pr__nfet_01v8 ad=0.29 pd=2.29 as=0.29 ps=2.29 w=2 l=1
X2 D4 G S3 B sky130_fd_pr__nfet_01v8 ad=0.29 pd=2.29 as=0.29 ps=2.29 w=2 l=1
X3 S4 G D4 B sky130_fd_pr__nfet_01v8 ad=0.58 pd=4.58 as=0.29 ps=2.29 w=2 l=1
X4 S3 G D2 B sky130_fd_pr__nfet_01v8 ad=0.29 pd=2.29 as=0.29 ps=2.29 w=2 l=1
.ends

.subckt sky130_fd_pr__pfet_01v8_BS784P B D0 G S1 D2 S3 D4 S4
X0 D4 G S3 B sky130_fd_pr__pfet_01v8 ad=0.58 pd=4.29 as=0.58 ps=4.29 w=4 l=1
X1 S4 G D4 B sky130_fd_pr__pfet_01v8 ad=1.16 pd=8.58 as=0.58 ps=4.29 w=4 l=1
X2 S3 G D2 B sky130_fd_pr__pfet_01v8 ad=0.58 pd=4.29 as=0.58 ps=4.29 w=4 l=1
X3 S1 G D0 B sky130_fd_pr__pfet_01v8 ad=0.58 pd=4.29 as=1.16 ps=8.58 w=4 l=1
X4 D2 G S1 B sky130_fd_pr__pfet_01v8 ad=0.58 pd=4.29 as=0.58 ps=4.29 w=4 l=1
.ends

.subckt sky130_fd_pr__nfet_01v8_6CS3TQ B D0 G S1 D2 S3 D4 S4
X0 D2 G S1 B sky130_fd_pr__nfet_01v8 ad=0.58 pd=4.29 as=0.58 ps=4.29 w=4 l=1
X1 D4 G S3 B sky130_fd_pr__nfet_01v8 ad=0.58 pd=4.29 as=0.58 ps=4.29 w=4 l=1
X2 S4 G D4 B sky130_fd_pr__nfet_01v8 ad=1.16 pd=8.58 as=0.58 ps=4.29 w=4 l=1
X3 S3 G D2 B sky130_fd_pr__nfet_01v8 ad=0.58 pd=4.29 as=0.58 ps=4.29 w=4 l=1
X4 S1 G D0 B sky130_fd_pr__nfet_01v8 ad=0.58 pd=4.29 as=1.16 ps=8.58 w=4 l=1
.ends

.subckt sky130_fd_pr__nfet_01v8_NWZ7BA B D0 G S1 D2 S3 D4 S5 D6 S7 D8 S9 a_1661_n490#
X0 D8 G S7 B sky130_fd_pr__nfet_01v8 ad=0.7105 pd=5.19 as=0.7105 ps=5.19 w=4.9 l=1.4
X1 S5 G D4 B sky130_fd_pr__nfet_01v8 ad=0.7105 pd=5.19 as=0.7105 ps=5.19 w=4.9 l=1.4
X2 a_1661_n490# G S9 B sky130_fd_pr__nfet_01v8 ad=1.421 pd=10.38 as=0.7105 ps=5.19 w=4.9 l=1.4
X3 S1 G D0 B sky130_fd_pr__nfet_01v8 ad=0.7105 pd=5.19 as=1.421 ps=10.38 w=4.9 l=1.4
X4 S3 G D2 B sky130_fd_pr__nfet_01v8 ad=0.7105 pd=5.19 as=0.7105 ps=5.19 w=4.9 l=1.4
X5 S9 G D8 B sky130_fd_pr__nfet_01v8 ad=0.7105 pd=5.19 as=0.7105 ps=5.19 w=4.9 l=1.4
X6 S7 G D6 B sky130_fd_pr__nfet_01v8 ad=0.7105 pd=5.19 as=0.7105 ps=5.19 w=4.9 l=1.4
X7 D2 G S1 B sky130_fd_pr__nfet_01v8 ad=0.7105 pd=5.19 as=0.7105 ps=5.19 w=4.9 l=1.4
X8 D4 G S3 B sky130_fd_pr__nfet_01v8 ad=0.7105 pd=5.19 as=0.7105 ps=5.19 w=4.9 l=1.4
X9 D6 G S5 B sky130_fd_pr__nfet_01v8 ad=0.7105 pd=5.19 as=0.7105 ps=5.19 w=4.9 l=1.4
.ends

.subckt sky130_fd_pr__pfet_01v8_J8A8UZ B D0 G S1 D2 S3 D4 S4
X0 S4 G D4 B sky130_fd_pr__pfet_01v8 ad=4.06 pd=28.58 as=2.03 ps=14.29 w=14 l=3.2
X1 D4 G S3 B sky130_fd_pr__pfet_01v8 ad=2.03 pd=14.29 as=2.03 ps=14.29 w=14 l=3.2
X2 S1 G D0 B sky130_fd_pr__pfet_01v8 ad=2.03 pd=14.29 as=4.06 ps=28.58 w=14 l=3.2
X3 D2 G S1 B sky130_fd_pr__pfet_01v8 ad=2.03 pd=14.29 as=2.03 ps=14.29 w=14 l=3.2
X4 S3 G D2 B sky130_fd_pr__pfet_01v8 ad=2.03 pd=14.29 as=2.03 ps=14.29 w=14 l=3.2
.ends

.subckt sky130_fd_pr__pfet_01v8_PR8SW8 B D0 G S1 D2 S3 D4 S4
X0 S3 G D2 B sky130_fd_pr__pfet_01v8 ad=1.16 pd=8.29 as=1.16 ps=8.29 w=8 l=1
X1 S1 G D0 B sky130_fd_pr__pfet_01v8 ad=1.16 pd=8.29 as=2.32 ps=16.58 w=8 l=1
X2 D2 G S1 B sky130_fd_pr__pfet_01v8 ad=1.16 pd=8.29 as=1.16 ps=8.29 w=8 l=1
X3 S4 G D4 B sky130_fd_pr__pfet_01v8 ad=2.32 pd=16.58 as=1.16 ps=8.29 w=8 l=1
X4 D4 G S3 B sky130_fd_pr__pfet_01v8 ad=1.16 pd=8.29 as=1.16 ps=8.29 w=8 l=1
.ends

.subckt sky130_fd_pr__nfet_01v8_68KXJR B D0 G S1 D2 S3 D4 S4
X0 D2 G S1 B sky130_fd_pr__nfet_01v8 ad=1.16 pd=8.29 as=1.16 ps=8.29 w=8 l=4.2
X1 D4 G S3 B sky130_fd_pr__nfet_01v8 ad=1.16 pd=8.29 as=1.16 ps=8.29 w=8 l=4.2
X2 S4 G D4 B sky130_fd_pr__nfet_01v8 ad=2.32 pd=16.58 as=1.16 ps=8.29 w=8 l=4.2
X3 S3 G D2 B sky130_fd_pr__nfet_01v8 ad=1.16 pd=8.29 as=1.16 ps=8.29 w=8 l=4.2
X4 S1 G D0 B sky130_fd_pr__nfet_01v8 ad=1.16 pd=8.29 as=2.32 ps=16.58 w=8 l=4.2
.ends

.subckt sky130_fd_pr__pfet_01v8_3VA8U9 B D0 G S1 D2 S3 D4 S4
X0 S4 G D4 B sky130_fd_pr__pfet_01v8 ad=4.06 pd=28.58 as=2.03 ps=14.29 w=14 l=3.2
X1 D4 G S3 B sky130_fd_pr__pfet_01v8 ad=2.03 pd=14.29 as=2.03 ps=14.29 w=14 l=3.2
X2 S1 G D0 B sky130_fd_pr__pfet_01v8 ad=2.03 pd=14.29 as=4.06 ps=28.58 w=14 l=3.2
X3 D2 G S1 B sky130_fd_pr__pfet_01v8 ad=2.03 pd=14.29 as=2.03 ps=14.29 w=14 l=3.2
X4 S3 G D2 B sky130_fd_pr__pfet_01v8 ad=2.03 pd=14.29 as=2.03 ps=14.29 w=14 l=3.2
.ends

.subckt sky130_fd_pr__nfet_01v8_CRPCLH B D0 G S1 D2 S3 D4 S4
X0 D2 G S1 B sky130_fd_pr__nfet_01v8 ad=1.16 pd=8.29 as=1.16 ps=8.29 w=8 l=4.2
X1 D4 G S3 B sky130_fd_pr__nfet_01v8 ad=1.16 pd=8.29 as=1.16 ps=8.29 w=8 l=4.2
X2 S4 G D4 B sky130_fd_pr__nfet_01v8 ad=2.32 pd=16.58 as=1.16 ps=8.29 w=8 l=4.2
X3 S3 G D2 B sky130_fd_pr__nfet_01v8 ad=1.16 pd=8.29 as=1.16 ps=8.29 w=8 l=4.2
X4 S1 G D0 B sky130_fd_pr__nfet_01v8 ad=1.16 pd=8.29 as=2.32 ps=16.58 w=8 l=4.2
.ends

.subckt sky130_fd_pr__pfet_01v8_8ULR7S B D0 G S1 D2 S3 D4 S5 D6 S7 D8 S9 a_1661_n740#
X0 S9 G D8 B sky130_fd_pr__pfet_01v8 ad=1.073 pd=7.69 as=1.073 ps=7.69 w=7.4 l=1.4
X1 D2 G S1 B sky130_fd_pr__pfet_01v8 ad=1.073 pd=7.69 as=1.073 ps=7.69 w=7.4 l=1.4
X2 S7 G D6 B sky130_fd_pr__pfet_01v8 ad=1.073 pd=7.69 as=1.073 ps=7.69 w=7.4 l=1.4
X3 D4 G S3 B sky130_fd_pr__pfet_01v8 ad=1.073 pd=7.69 as=1.073 ps=7.69 w=7.4 l=1.4
X4 D6 G S5 B sky130_fd_pr__pfet_01v8 ad=1.073 pd=7.69 as=1.073 ps=7.69 w=7.4 l=1.4
X5 D8 G S7 B sky130_fd_pr__pfet_01v8 ad=1.073 pd=7.69 as=1.073 ps=7.69 w=7.4 l=1.4
X6 S5 G D4 B sky130_fd_pr__pfet_01v8 ad=1.073 pd=7.69 as=1.073 ps=7.69 w=7.4 l=1.4
X7 a_1661_n740# G S9 B sky130_fd_pr__pfet_01v8 ad=2.146 pd=15.38 as=1.073 ps=7.69 w=7.4 l=1.4
X8 S1 G D0 B sky130_fd_pr__pfet_01v8 ad=1.073 pd=7.69 as=2.146 ps=15.38 w=7.4 l=1.4
X9 S3 G D2 B sky130_fd_pr__pfet_01v8 ad=1.073 pd=7.69 as=1.073 ps=7.69 w=7.4 l=1.4
.ends

.subckt vco VDD out vctrl GND
XXM15 GND GND XM4/G XM17/G GND XM17/G GND XM17/G sky130_fd_pr__nfet_01v8_QMGPN5
XXM16 VDD VDD XM4/G XM17/G VDD XM17/G VDD XM17/G sky130_fd_pr__pfet_01v8_BS784P
XXM17 GND out XM17/G GND out GND out GND sky130_fd_pr__nfet_01v8_6CS3TQ
Xsky130_fd_pr__nfet_01v8_NWZ7BA_0 GND sky130_fd_pr__pfet_01v8_8ULR7S_2/G XM4/D8 sky130_fd_pr__nfet_01v8_NWZ7BA_0/S9
+ sky130_fd_pr__pfet_01v8_8ULR7S_2/G sky130_fd_pr__nfet_01v8_NWZ7BA_0/S9 sky130_fd_pr__pfet_01v8_8ULR7S_2/G
+ sky130_fd_pr__nfet_01v8_NWZ7BA_0/S9 sky130_fd_pr__pfet_01v8_8ULR7S_2/G sky130_fd_pr__nfet_01v8_NWZ7BA_0/S9
+ sky130_fd_pr__pfet_01v8_8ULR7S_2/G sky130_fd_pr__nfet_01v8_NWZ7BA_0/S9 sky130_fd_pr__pfet_01v8_8ULR7S_2/G
+ sky130_fd_pr__nfet_01v8_NWZ7BA
Xsky130_fd_pr__nfet_01v8_NWZ7BA_1 GND XM4/G sky130_fd_pr__pfet_01v8_8ULR7S_2/G sky130_fd_pr__nfet_01v8_NWZ7BA_1/S9
+ XM4/G sky130_fd_pr__nfet_01v8_NWZ7BA_1/S9 XM4/G sky130_fd_pr__nfet_01v8_NWZ7BA_1/S9
+ XM4/G sky130_fd_pr__nfet_01v8_NWZ7BA_1/S9 XM4/G sky130_fd_pr__nfet_01v8_NWZ7BA_1/S9
+ XM4/G sky130_fd_pr__nfet_01v8_NWZ7BA
XXM1 VDD VDD XM7/G XM1/S4 VDD XM1/S4 VDD XM1/S4 sky130_fd_pr__pfet_01v8_J8A8UZ
XXM4 GND XM4/D8 XM4/G XM5/S4 XM4/D8 XM5/S4 XM4/D8 XM5/S4 XM4/D8 XM5/S4 XM4/D8 XM5/S4
+ XM4/D8 sky130_fd_pr__nfet_01v8_NWZ7BA
Xsky130_fd_pr__pfet_01v8_PR8SW8_0 VDD VDD XM17/G out VDD out VDD out sky130_fd_pr__pfet_01v8_PR8SW8
XXM5 GND GND vctrl XM5/S4 GND XM5/S4 GND XM5/S4 sky130_fd_pr__nfet_01v8_68KXJR
XXM7 VDD VDD XM7/G XM7/G VDD XM7/G VDD XM7/G sky130_fd_pr__pfet_01v8_3VA8U9
XXM8 GND XM7/G vctrl GND XM7/G GND XM7/G GND sky130_fd_pr__nfet_01v8_CRPCLH
Xsky130_fd_pr__pfet_01v8_J8A8UZ_0 VDD VDD XM7/G sky130_fd_pr__pfet_01v8_8ULR7S_2/B
+ VDD sky130_fd_pr__pfet_01v8_8ULR7S_2/B VDD sky130_fd_pr__pfet_01v8_8ULR7S_2/B sky130_fd_pr__pfet_01v8_J8A8UZ
Xsky130_fd_pr__pfet_01v8_J8A8UZ_1 VDD VDD XM7/G sky130_fd_pr__pfet_01v8_8ULR7S_1/B
+ VDD sky130_fd_pr__pfet_01v8_8ULR7S_1/B VDD sky130_fd_pr__pfet_01v8_8ULR7S_1/B sky130_fd_pr__pfet_01v8_J8A8UZ
Xsky130_fd_pr__pfet_01v8_8ULR7S_1 sky130_fd_pr__pfet_01v8_8ULR7S_1/B sky130_fd_pr__pfet_01v8_8ULR7S_2/G
+ XM4/D8 sky130_fd_pr__pfet_01v8_8ULR7S_1/B sky130_fd_pr__pfet_01v8_8ULR7S_2/G sky130_fd_pr__pfet_01v8_8ULR7S_1/B
+ sky130_fd_pr__pfet_01v8_8ULR7S_2/G sky130_fd_pr__pfet_01v8_8ULR7S_1/B sky130_fd_pr__pfet_01v8_8ULR7S_2/G
+ sky130_fd_pr__pfet_01v8_8ULR7S_1/B sky130_fd_pr__pfet_01v8_8ULR7S_2/G sky130_fd_pr__pfet_01v8_8ULR7S_1/B
+ sky130_fd_pr__pfet_01v8_8ULR7S_2/G sky130_fd_pr__pfet_01v8_8ULR7S
Xsky130_fd_pr__pfet_01v8_8ULR7S_0 XM1/S4 XM4/D8 XM4/G XM1/S4 XM4/D8 XM1/S4 XM4/D8
+ XM1/S4 XM4/D8 XM1/S4 XM4/D8 XM1/S4 XM4/D8 sky130_fd_pr__pfet_01v8_8ULR7S
Xsky130_fd_pr__pfet_01v8_8ULR7S_2 sky130_fd_pr__pfet_01v8_8ULR7S_2/B XM4/G sky130_fd_pr__pfet_01v8_8ULR7S_2/G
+ sky130_fd_pr__pfet_01v8_8ULR7S_2/B XM4/G sky130_fd_pr__pfet_01v8_8ULR7S_2/B XM4/G
+ sky130_fd_pr__pfet_01v8_8ULR7S_2/B XM4/G sky130_fd_pr__pfet_01v8_8ULR7S_2/B XM4/G
+ sky130_fd_pr__pfet_01v8_8ULR7S_2/B XM4/G sky130_fd_pr__pfet_01v8_8ULR7S
Xsky130_fd_pr__nfet_01v8_68KXJR_0 GND GND vctrl sky130_fd_pr__nfet_01v8_NWZ7BA_0/S9
+ GND sky130_fd_pr__nfet_01v8_NWZ7BA_0/S9 GND sky130_fd_pr__nfet_01v8_NWZ7BA_0/S9
+ sky130_fd_pr__nfet_01v8_68KXJR
Xsky130_fd_pr__nfet_01v8_68KXJR_1 GND GND vctrl sky130_fd_pr__nfet_01v8_NWZ7BA_1/S9
+ GND sky130_fd_pr__nfet_01v8_NWZ7BA_1/S9 GND sky130_fd_pr__nfet_01v8_NWZ7BA_1/S9
+ sky130_fd_pr__nfet_01v8_68KXJR
.ends
