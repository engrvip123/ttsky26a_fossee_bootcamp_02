** sch_path: /home/vncuser/design_data/test_design/xschem/DIFF_AMP.sch
.subckt DIFF_AMP VDD vinm vinn vbias VSS out
*.iopin out
*.iopin VDD
*.iopin vinn
*.iopin vinm
*.iopin vbias
*.iopin VSS
XM1 net1 vinn net2 VSS sky130_fd_pr__nfet_01v8 L=0.5 W=40 nf=1 ad=11.6 as=11.6 pd=80.58 ps=80.58 nrd=0.00725 nrs=0.00725 sa=0 sb=0
+ sd=0 mult=1
XM2 out vinm net2 VSS sky130_fd_pr__nfet_01v8 L=0.5 W=40 nf=1 ad=11.6 as=11.6 pd=80.58 ps=80.58 nrd=0.00725 nrs=0.00725 sa=0 sb=0
+ sd=0 mult=1
XM3 net2 vbias VSS VSS sky130_fd_pr__nfet_01v8 L=0.5 W=16 nf=1 ad=4.64 as=4.64 pd=32.58 ps=32.58 nrd=0.018125 nrs=0.018125 sa=0
+ sb=0 sd=0 mult=1
XM4 net1 net1 VDD VDD sky130_fd_pr__pfet_01v8 L=0.5 W=80 nf=1 ad=23.2 as=23.2 pd=160.58 ps=160.58 nrd=0.003625 nrs=0.003625 sa=0
+ sb=0 sd=0 mult=1
XM5 out net1 VDD VDD sky130_fd_pr__pfet_01v8 L=0.5 W=80 nf=1 ad=23.2 as=23.2 pd=160.58 ps=160.58 nrd=0.003625 nrs=0.003625 sa=0
+ sb=0 sd=0 mult=1
.ends DIFF_AMP
.end
